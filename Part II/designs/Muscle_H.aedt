# Ansys Electronics Desktop project, version 2024.2
project datasets:
  $bone_cortical_epsilon_r: (10, 55153) (15.849, 33607) (25.119, 18782) (39.811, 10989) (63.096, 7430.4) (100, 5852.8) (158.49, 5072.8) (251.19, 4544.3) (398.11, 4019.4) (630.96, 3401.3) (1000, 2702.4) (1584.9, 2012.5) (2511.9, 1429.9) (3981.1, 999.15) (6309.6, 708.37) (10000, 521.64) (15849, 403.89) (25119, 329.39) (39811, 281.45) (63096, 249.69) (100000, 227.64) (158490, 211.05) (251190, 196.84) (398110, 182.43) (630960, 165.53) (1000000, 144.51) (1584900, 119.48) (2511900, 93.01) (3981100, 68.959) (6309600, 50.062) (10000000, 36.772) (15849000, 28.041) (25119000, 22.486) (39811000, 18.975) (63096000, 16.736) (100000000, 15.283) (158490000, 14.314) (251190000, 13.645) (398110000, 13.152) (630960000, 12.749) (1000000000, 12.363) (1584900000, 11.923) (2511900000, 11.345) (3981100000, 10.541) (6309600000, 9.4543) (10000000000, 8.1197)
  $bone_cortical_conductivity: (10, 0.020028) (15.849, 0.02004) (25.119, 0.020048) (39.811, 0.020053) (63.096, 0.020056) (100, 0.020059) (158.49, 0.020063) (251.19, 0.020072) (398.11, 0.020089) (630.96, 0.020116) (1000, 0.020157) (1584.9, 0.020208) (2511.9, 0.020264) (3981.1, 0.020321) (6309.6, 0.020376) (10000, 0.02043) (15849, 0.020484) (25119, 0.020542) (39811, 0.020606) (63096, 0.020684) (100000, 0.020791) (158490, 0.020957) (251190, 0.021243) (398110, 0.021764) (630960, 0.022714) (1000000, 0.024353) (1584900, 0.026899) (2511900, 0.030344) (3981100, 0.03439) (6309600, 0.038636) (10000000, 0.042822) (15849000, 0.046888) (25119000, 0.050904) (39811000, 0.055008) (63096000, 0.059382) (100000000, 0.064313) (158490000, 0.070326) (251190000, 0.078503) (398110000, 0.091168) (630960000, 0.11334) (1000000000, 0.15566) (1584900000, 0.23975) (2511900000, 0.40645) (3981100000, 0.72317) (6309600000, 1.2772) (10000000000, 2.1359)
  $BoneCortical_Epsr1: (10, 55153) (15.849, 33607) (25.119, 18782) (39.811, 10989) (63.096, 7430.4) (100, 5852.8) (158.49, 5072.8) (251.19, 4544.3) (398.11, 4019.4) (630.96, 3401.3) (1000, 2702.4) (1584.9, 2012.5) (2511.9, 1429.9) (3981.1, 999.15) (6309.6, 708.37) (10000, 521.64) (15849, 403.89) (25119, 329.39) (39811, 281.45) (63096, 249.69) (100000, 227.64) (158490, 211.05) (251190, 196.84) (398110, 182.43) (630960, 165.53) (1000000, 144.51) (1584900, 119.48) (2511900, 93.01) (3981100, 68.959) (6309600, 50.062) (10000000, 36.772) (15849000, 28.041) (25119000, 22.486) (39811000, 18.975) (63096000, 16.736) (100000000, 15.283) (158490000, 14.314) (251190000, 13.645) (398110000, 13.152) (630960000, 12.749) (1000000000, 12.363) (1584900000, 11.923) (2511900000, 11.345) (3981100000, 10.541) (6309600000, 9.4543) (10000000000, 8.1197)
  $BoneCortical_Cond1: (10, 0.020028) (15.849, 0.02004) (25.119, 0.020048) (39.811, 0.020053) (63.096, 0.020056) (100, 0.020059) (158.49, 0.020063) (251.19, 0.020072) (398.11, 0.020089) (630.96, 0.020116) (1000, 0.020157) (1584.9, 0.020208) (2511.9, 0.020264) (3981.1, 0.020321) (6309.6, 0.020376) (10000, 0.02043) (15849, 0.020484) (25119, 0.020542) (39811, 0.020606) (63096, 0.020684) (100000, 0.020791) (158490, 0.020957) (251190, 0.021243) (398110, 0.021764) (630960, 0.022714) (1000000, 0.024353) (1584900, 0.026899) (2511900, 0.030344) (3981100, 0.03439) (6309600, 0.038636) (10000000, 0.042822) (15849000, 0.046888) (25119000, 0.050904) (39811000, 0.055008) (63096000, 0.059382) (100000000, 0.064313) (158490000, 0.070326) (251190000, 0.078503) (398110000, 0.091168) (630960000, 0.11334) (1000000000, 0.15566) (1584900000, 0.23975) (2511900000, 0.40645) (3981100000, 0.72317) (6309600000, 1.2772) (10000000000, 2.1359)
materials:
  Implant5: permittivity=5
  humanbone_cortical: permittivity=pwl($bone_cortical_epsilon_r,Freq) conductivity=pwl($bone_cortical_conductivity,Freq)
  implant10: permittivity=10
  implant1_6: permittivity=1.6
  implant2: permittivity=2
  implant3: permittivity=3
  implant4: permittivity=4
  implant7: permittivity=7
  implant_1_8: permittivity=1.8
  implant_2_5: permittivity=2.5
  vacuum: permittivity=1
  Rogers RO3210 (tm): permittivity=10.2 dielectric_loss_tangent=0.003
  Material1: permittivity=52.8 conductivity=1.71 dielectric_loss_tangent=0.24256177
  silicon: permittivity=11.9 mass_density=2330
  FR4_epoxy: permittivity=4.4 dielectric_loss_tangent=0.02 mass_density=1900
  Rogers RO3003 (tm): permittivity=3 dielectric_loss_tangent=0.0013
  air: permittivity=1.0006 permeability=1.0000004 mass_density=1.1614
  Rogers RT/duroid 6010/6010LM (tm): permittivity=10.2 dielectric_loss_tangent=0.0023
  Rogers RT/duroid 6006 (tm): permittivity=6.15 dielectric_loss_tangent=0.0019
  pec: conductivity=1e+30
  BoneCortical: permittivity=pwl($BoneCortical_Epsr1,Freq) conductivity=pwl($BoneCortical_Cond1,Freq)
  izibone: permittivity=12
  Duroid (tm): permittivity=2.2 dielectric_loss_tangent=0.0009
  bone_cort_2.4ghz: permittivity=11 conductivity=0.385 delta_H_freq=2.4GHz

design single_antenna_H (HFSS, HFSS Terminal Network, model units mm)
options: Allow_Material_Override Save_Adaptive_support_files
variables:
  # Patch Dimensions
  patchX = 6mm
  patchY = patchX
  # Substrate Dimensions
  subH = subH1
  subX = patchX
  subY = patchY
  # Feed
  feed_length = 5mm
  # Air Box
  Airbox_dist = 50mm
  # Virtual Object Radiation Surface
  VirtualObject_dist = 2.9979mm
  subH1 = 0.5mm
  subH1_6 = 0mm
  subH1_8 = 0mm
  subH2 = 0mm
  subH2_5 = 0mm
  subH3 = 0mm
  subH4 = 0mm
  subH5 = 0mm
  subH7 = 0mm
  subH10 = 0mm
  slot_width = 0.45mm
  muscleZ = 90mm
  muscleZ_back = 10mm
  feed_width = SubH10*0.13+subH7*0.24+subH5*0.35+subH4*0.45+subH3*0.55+subH2_5*0.65+subH2*0.75+subH1_8*0.8+subH1_6*0.85+subH1*1.07
  x_extend = -3mm
  y_extend = 0.8mm
  x_pos = 0mm
  y_pos = 0mm
  muscleR = 20mm
  feedpos = 4mm
  starter = 0.6mm
geometry:
  Ground = rectangle(corner=(-subX/2, -subY/2, 0mm), x_size=subX, y_size=subY)
  patch = rectangle(corner=(-patchX/2, -patchY/2, subH), x_size=patchX, y_size=patchY)
  AirBox [vacuum] = box(corner=(-muscleR/2 - Airbox_dist, -muscleR/2 - Airbox_dist, -muscleR/2- Airbox_dist+30mm), size=(muscleR + 2*Airbox_dist, muscleR + 2*Airbox_dist, muscleR + 2*Airbox_dist-30mm))
  implant2_5 [implant_2_5] = box(corner=(-subX/2, -subY/2, 0mm), size=(subX, subY, subH2_5*2))
  implant1_8 [implant_1_8] = box(corner=(-subX/2, -subY/2, 0mm), size=(subX, subY, subH1_8*2))
  implant10 [implant10] = box(corner=(-subX/2, -subY/2, 0mm), size=(subX, subY, subH10*2))
  implant7 [implant7] = box(corner=(-subX/2, -subY/2, 0mm), size=(subX, subY, subH7*2))
  implant5 [Implant5] = box(corner=(-subX/2, -subY/2, 0mm), size=(subX, subY, subH5*2))
  implant4 [implant4] = box(corner=(-subX/2, -subY/2, 0mm), size=(subX, subY, subH4*2))
  implant3 [implant3] = box(corner=(-subX/2, -subY/2, 0mm), size=(subX, subY, subH3*2))
  implant2 [implant2] = box(corner=(-subX/2, -subY/2, 0mm), size=(subX, subY, subH2*2))
  patch1 = rectangle(corner=(-patchX/2+starter, -patchY/2, subH), x_size=slot_width, y_size=patchY)
  patch3 = rectangle(corner=(-patchX/2+starter+slot_width, -patchY/2, subH), x_size=patchX-starter-slot_width, y_size=slot_width)
  patch4 = rectangle(corner=(patchX/2, -patchY/2+slot_width, subH), x_size=-slot_width, y_size=patchY-slot_width)
  patch5 = rectangle(corner=(patchX/2-slot_width, patchY/2, subH), x_size=-patchX+3*slot_width+starter, y_size=-slot_width)
  patch6 = rectangle(corner=(-patchX/2+starter+3*slot_width, -patchY/2+2*slot_width, subH), x_size=-slot_width, y_size=patchY-3*slot_width)
  patch7 = rectangle(corner=(-patchX/2+3*slot_width+starter, -patchY/2+2*slot_width, subH), x_size=patchX-5*slot_width-starter, y_size=slot_width)
  patch8 = rectangle(corner=(patchX/2-3*slot_width, patchY/2-2*slot_width, subH), x_size=slot_width, y_size=-patchX+5*slot_width)
  patch9 = rectangle(corner=(patchX/2-3*slot_width, patchY/2-2*slot_width, subH), x_size=-patchX+7*slot_width+starter, y_size=-slot_width)
  patch10 = rectangle(corner=(-patchX/2+starter+5*slot_width, -patchY/2+4*slot_width, subH), x_size=-slot_width, y_size=patchY-7*slot_width)
  Y_wall_minus = rectangle(corner=(-subX/2, -subY/2, 0mm), z_size=subH, x_size=subY)
  Y_wall_plus = rectangle(corner=(-subX/2, subY/2, 0mm), z_size=subH, x_size=subY)
  X_wall_minus = rectangle(corner=(-subX/2, -subY/2, 0mm), z_size=subX*0.0001, x_size=subH*0.0001)
  X_wall_plus = rectangle(corner=(subX/2, -subY/2, 0mm), y_size=subX, z_size=subH)
  Ground.unite(X_wall_minus, X_wall_plus, Y_wall_minus, Y_wall_plus)
  feed = rectangle(corner=(-patchX/2+0.5mm, patchy/2-1.5*slot_width+feed_width/2-feedpos, subH/2), x_size=feed_length*0.0001, y_size=-feed_width*0.0001)
  feed1 = rectangle(corner=(-patchX/2+0.5mm, patchy/2-1.5*slot_width-feed_width/2-feedpos, subH/2), x_size=-0.5mm, y_size=feed_width)
  patch11 = rectangle(corner=(-patchX/2+5*slot_width+starter, -patchY/2+4*slot_width, subH), x_size=patchx-9*slot_width-starter, y_size=slot_width)
  patch12 = rectangle(corner=(patchX/2-4*slot_width, -patchY/2+5*slot_width, subH), x_size=-slot_width, y_size=patchY-9*slot_width)
  patch13 = rectangle(corner=(patchX/2-5*slot_width, patchY/2-5*slot_width, subH), x_size=-patchX+11*slot_width+starter, y_size=slot_width)
  patch14 = rectangle(corner=(-patchX/2+6*slot_width +starter, -patchY/2+6*slot_width, subH), x_size=slot_width, y_size=patchY-11*slot_width)
  patch.subtract(patch1, patch10..patch14, patch3..patch9)
  implant1 [Rogers RO3210 (tm)] = box(corner=(-subX/2, -subY/2, 0mm), size=(subX, subY, subH1*2))
  implant1_6 [implant1_6] = box(corner=(-subX/2, -subY/2, 0mm), size=(subX, subY, subH1_6*2))
  Sphere1 [Material1, not solved inside] = sphere(centre=(0mm, 0mm, SubH), radius=muscleR)
  Box1 = box(corner=(-muscler, -muscler, -40mm), size=(muscler*2, muscleR*2, -50mm))
  Sphere1.subtract(Box1)
  microstrip = rectangle(corner=(-patchX/2+0.5mm, patchy/2-1.5*slot_width-feed_width/2-feedpos, subH/2), x_size=feed_length, y_size=feed_width)
  XminusWall = rectangle(corner=(-patchX/2, patchY/2, 0mm), y_size=-patchY, z_size=subH)
boundaries and excitations:
  Rad: Radiation Objects=AirBox
  feed: Perfect E Objects=feed
  PerfE1: Perfect E Objects=microstrip InfGroundPlane
  XminusWall: Perfect E Objects=XminusWall
  patch: Perfect E Objects=patch
  ground: Perfect E Objects=Ground
  reference conductors: feed, microstrip
setups:
  freq: HfssDriven Frequency=0.3176GHz MaxDeltaE=0.1 MaximumPasses=15 MinimumPasses=1 MinimumConvergedPasses=1 PercentRefinement=30 BasisOrder=1 DrivenSolverType="Direct Solver"
  freq2: HfssDriven Frequency=3.7984GHz MaxDeltaE=0.1 MaximumPasses=15 MinimumPasses=1 MinimumConvergedPasses=1 PercentRefinement=30 BasisOrder=1 DrivenSolverType="Direct Solver"
  Setup1: HfssDriven Frequency=9GHz MaxDeltaE=0.1 MaximumPasses=6 MinimumPasses=1 MinimumConvergedPasses=1 PercentRefinement=30 BasisOrder=1 DrivenSolverType="Direct Solver"
radiation setups:
  Infinite Sphere1: Infinite Sphere Theta=0deg..180deg step 10deg Phi=0deg..360deg step 10deg
output variables:
  eff = RadiatedPower/AcceptedPower
  emis_multiplicator = IncidentPower/AcceptedPower

design turn_number (HFSS, HFSS Terminal Network, model units mm)
options: Allow_Material_Override Save_Adaptive_support_files
variables:
  # Patch Dimensions
  patchX = 6mm
  patchY = patchX
  # Substrate Dimensions
  subH = subH1
  subX = patchX
  subY = patchY
  # Feed
  feed_length = 6mm
  # Air Box
  Airbox_dist = 120mm
  # Virtual Object Radiation Surface
  VirtualObject_dist = 2.9979mm
  subH1 = 3.2mm
  subH1_6 = 0mm
  subH1_8 = 0mm
  subH2 = 0mm
  subH2_5 = 0mm
  subH3 = 0mm
  subH4 = 0mm
  subH5 = 0mm
  subH7 = 0mm
  subH10 = 0mm
  slot_width = 0.75mm
  muscleZ = 90mm
  muscleZ_back = 10mm
  feed_width = 3mm
  x_extend = -3mm
  y_extend = 0.8mm
  x_pos = 0mm
  y_pos = 0mm
  muscleR = 200mm
  feedpos = 1.2mm
  starter = 0.6mm
  siliconR = 6mm
  starter_y_minus = 0.4mm
  starter_y_plus = 0.5mm
  starter_x_plus = 0.5m
geometry:
  patch = rectangle(corner=(-patchX/2, -patchY/2, subH), x_size=patchX, y_size=patchY)
  AirBox [vacuum] = box(corner=(-muscleR/2 - Airbox_dist, -muscleR/2 - Airbox_dist, -muscleR/2- Airbox_dist), size=(muscleR + 2*Airbox_dist, muscleR + 2*Airbox_dist, muscleR + 2*Airbox_dist))
  implant2_5 [implant_2_5] = box(corner=(-subX/2, -subY/2, 0mm), size=(subX, subY, subH2_5*2))
  implant1_8 [implant_1_8] = box(corner=(-subX/2, -subY/2, 0mm), size=(subX, subY, subH1_8*2))
  implant10 [implant10] = box(corner=(-subX/2, -subY/2, 0mm), size=(subX, subY, subH10*2))
  implant7 [implant7] = box(corner=(-subX/2, -subY/2, 0mm), size=(subX, subY, subH7*2))
  implant5 [Implant5] = box(corner=(-subX/2, -subY/2, 0mm), size=(subX, subY, subH5*2))
  implant4 [implant4] = box(corner=(-subX/2, -subY/2, 0mm), size=(subX, subY, subH4*2))
  implant3 [implant3] = box(corner=(-subX/2, -subY/2, 0mm), size=(subX, subY, subH3*2))
  implant2 [implant2] = box(corner=(-subX/2, -subY/2, 0mm), size=(subX, subY, subH2*2))
  patch1 = rectangle(corner=(-patchX/2+starter, -patchY/2+starter_y_minus, subH), x_size=slot_width, y_size=patchY-starter_y_minus-starter_y_plus)
  patch3 = rectangle(corner=(-patchX/2+starter+slot_width, -patchY/2+starter_y_minus, subH), x_size=patchX-starter-slot_width-starter_x_plus, y_size=slot_width)
  patch4 = rectangle(corner=(patchX/2-starter_x_plus, -patchY/2+slot_width+starter_y_minus, subH), x_size=-slot_width, y_size=patchY-slot_width-starter_y_minus-starter_y_plus)
  patch5 = rectangle(corner=(patchX/2-slot_width-starter_x_plus, patchY/2-starter_y_plus, subH), x_size=-patchX+3*slot_width+starter+starter_x_plus, y_size=-slot_width)
  patch6 = rectangle(corner=(-patchX/2+starter+2*slot_width, -patchY/2+starter_y_minus+2*slot_width, subH), x_size=slot_width, y_size=patchY-3*slot_width-starter_y_plus-starter_y_minus)
  patch7 = rectangle(corner=(-patchX/2+3*slot_width+starter, -patchY/2+2*slot_width+starter_y_minus, subH), x_size=patchX-5*slot_width-starter-starter_x_plus, y_size=slot_width)
  feed = rectangle(corner=(-patchX/2+0.5mm, patchy/2-1.5*slot_width+feed_width/2-feedpos, subH/2), x_size=feed_length*0.0001, y_size=-feed_width*0.0001)
  feed1 = rectangle(corner=(-patchX/2, patchy/2-1.5*slot_width+feed_width/2-feedpos, subH1/2), y_size=-feed_width, z_size=subH1/2)
  implant1 [FR4_epoxy] = box(corner=(-subX/2, -subY/2, subH1/2), size=(subX, subY, subH1/2))
  implant1_6 [implant1_6] = box(corner=(-subX/2, -subY/2, 0mm), size=(subX, subY, subH1_6*2))
  Sphere1 [Material1, not solved inside] = sphere(centre=(0mm, 0mm, SubH), radius=muscleR)
  microstrip = rectangle(corner=(-patchX/2, patchy/2-1.5*slot_width-feed_width/2-feedpos, subH/2), x_size=feed_length, y_size=feed_width)
  patch.subtract(patch1)
  patch.subtract(patch3..patch7)
  Sphere2 [silicon] = sphere(centre=(0mm, 0mm, SubH), radius=siliconR)
  Box2 = box(corner=(-muscler, -muscler, -40mm), size=(muscler*2, muscleR*2, -50mm))
  Sphere2.subtract(Box2)
  Sphere3 = sphere(centre=(0mm, 0mm, SubH), radius=siliconR)
  Box3 = box(corner=(-muscler, -muscler, -40mm), size=(muscler*2, muscleR*2, -50mm))
  Sphere3.subtract(Box3)
  Sphere1.subtract(Sphere3)
  patch8 = rectangle(corner=(patchX/2-starter_x_plus-slot_width*2, -patchY/2+starter_y_minus+slot_width*3, subH1), x_size=-slot_width, y_size=patchY-starter_y_plus-starter_y_minus-slot_width*5)
  patch.subtract(patch8)
  patch9 = rectangle(corner=(-patchX/2+starter, -patchY/2+starter_y_minus, subH), x_size=slot_width, y_size=patchY-starter_y_minus-starter_y_plus)
  patch10 = rectangle(corner=(-patchX/2+starter+slot_width, -patchY/2+starter_y_minus, subH), x_size=patchX-starter-slot_width-starter_x_plus, y_size=slot_width)
  patch11 = rectangle(corner=(patchX/2-starter_x_plus, -patchY/2+slot_width+starter_y_minus, subH), x_size=-slot_width, y_size=patchY-slot_width-starter_y_minus-starter_y_plus)
  patch12 = rectangle(corner=(patchX/2-slot_width-starter_x_plus, patchY/2-starter_y_plus, subH), x_size=-patchX+3*slot_width+starter+starter_x_plus, y_size=-slot_width)
  patch13 = rectangle(corner=(-patchX/2+starter+2*slot_width, -patchY/2+starter_y_minus+2*slot_width, subH), x_size=slot_width, y_size=patchY-3*slot_width-starter_y_plus-starter_y_minus)
  patch14 [non-model] = rectangle(corner=(patchX/2-starter_x_plus-slot_width*2, -patchY/2+starter_y_minus+slot_width*3, subH1), x_size=-slot_width, y_size=patchY-starter_y_plus-starter_y_minus-slot_width*5)
  patch15 = rectangle(corner=(-patchX/2+3*slot_width+starter, -patchY/2+2*slot_width+starter_y_minus, subH), x_size=patchX-5*slot_width-starter-starter_x_plus, y_size=slot_width)
  implant11 [FR4_epoxy] = box(corner=(-subX/2, -subY/2, subH1/2), size=(subX, subY, subH1/2))
boundaries and excitations:
  Rad: Radiation Objects=AirBox
  feed: Perfect E Objects=feed
  PerfE1: Perfect E Objects=microstrip InfGroundPlane
  patch: Perfect E Objects=patch
  microstrip_T1: Terminal port=1 Edges=microstrip.edge(at (-3, 0.675, 1.6)) TerminalResistance=50ohm
  1: Lumped Port Faces=feed1.face(at (-3, 0.675, 2.4)) LumpedPortType=Terminal Impedance=50ohm
  reference conductors: microstrip, feed
setups:
  freq: HfssDriven Frequency=2.4GHz MaxDeltaS=0.02 MaximumPasses=15 MinimumPasses=1 MinimumConvergedPasses=1 PercentRefinement=30 BasisOrder=1 PortAccuracy=2 DrivenSolverType="Direct Solver"
  freq2: HfssDriven Frequency=3.7984GHz MaxDeltaS=0.02 MaximumPasses=15 MinimumPasses=1 MinimumConvergedPasses=1 PercentRefinement=30 BasisOrder=1 PortAccuracy=2 DrivenSolverType="Direct Solver"
  Setup1: HfssDriven Frequency=5GHz MaxDeltaS=0.01 MaximumPasses=20 MinimumPasses=1 MinimumConvergedPasses=1 PercentRefinement=30 BasisOrder=-1 PortAccuracy=2 DrivenSolverType="Direct Solver"
    sweep Sweep: 0.1GHz to 4GHz, 1500 points; Type=Interpolating InterpTolerance=0.5 InterpMaxSolns=50 PassivityErrorTolerance=0.0001
source amplitudes:
  1:1: 1V 0deg
optimetrics:
  ParametricSetup1: Parametric Sim._Setups=[Setup1]
    sweep feedpos: LIN 0.5mm 1.5mm 0.1mm
  ParametricSetup2: Parametric Sim._Setups=[Setup1, freq, freq2]
    sweep muscleR: LIN 20mm 60mm 10mm
radiation setups:
  Infinite Sphere1: Infinite Sphere Theta=0deg..180deg step 10deg Phi=0deg..360deg step 10deg
output variables:
  eff = RadiatedPower/AcceptedPower
  emis_multiplicator = IncidentPower/AcceptedPower
field plots:
  Mag_E1: E Field on freq : LastAdaptive at Freq=2.4GHz Phase=0deg
reports:
  Terminal S Parameter Plot 1: dB(St(microstrip_T1,microstrip_T1)) vs Freq on Setup1 : Sweep [muscleR=all]; markers m1 at 2.4077385GHz, m4 at 2.4545697GHz, m5 at 2.3765177GHz, m6 at 2.4545697GHz, m7 at 2.4103402GHz, MX1 at x=2.4e+09
  Gain Plot 1: dB(GainTotal) vs Phi, Theta on freq : LastAdaptive, Infinite Sphere1

design ImplantSimplyfyB (HFSS, HFSS Terminal Network, model units mm)
options: Allow_Material_Override Save_Adaptive_support_files
variables:
  # Patch Dimensions
  patchX = 14mm
  patchY = patchX
  # Substrate Dimensions
  subH = subH1
  subX = patchX
  subY = patchY
  # Feed
  feed_length = 6mm
  # Air Box
  Airbox_dist = 50mm
  # Virtual Object Radiation Surface
  VirtualObject_dist = 2.9979mm
  subH1 = 2mm
  subH1_6 = 0mm
  subH1_8 = 0mm
  subH2 = 0mm
  subH2_5 = 0mm
  subH3 = 0mm
  subH4 = 0mm
  subH5 = 0mm
  subH7 = 0mm
  subH10 = 0mm
  slot_width = 0.75mm
  muscleZ = 90mm
  muscleZ_back = 10mm
  feed_width = 0.8mm
  x_extend = -3mm
  y_extend = 0.8mm
  x_pos = 0mm
  y_pos = 0mm
  muscleR = 20mm
  feedpos = 1.2mm
  starter = 2.6mm
  siliconR = 15mm
  starter_y_minus = 2.4mm
  starter_y_plus = 2.5mm
  starter_x_plus = 2.5m
  feed_off = 3m
  Gap = 1mm
  lumped_feed_helper = 0.25mm
  feed_enter = 0.4m
  T_length = 2m
  T_width = 0.2mm
geometry:
  patch = rectangle(corner=(-patchX/2, -patchY/2, subH), x_size=patchX, y_size=patchY)
  AirBox [vacuum] = box(corner=(-muscleR/2 - Airbox_dist, -muscleR/2 - Airbox_dist, -muscleR/2- Airbox_dist), size=(muscleR + 2*Airbox_dist, muscleR + 2*Airbox_dist, muscleR + 2*Airbox_dist))
  patch1 = rectangle(corner=(-patchX/2+starter, -patchY/2+starter_y_minus, subH), x_size=slot_width, y_size=patchY-starter_y_minus-starter_y_plus)
  patch3 = rectangle(corner=(-patchX/2+starter+slot_width, -patchY/2+starter_y_minus, subH), x_size=patchX-starter-slot_width-starter_x_plus, y_size=slot_width)
  patch4 = rectangle(corner=(patchX/2-starter_x_plus, -patchY/2+slot_width+starter_y_minus, subH), x_size=-slot_width, y_size=patchY-slot_width-starter_y_minus-starter_y_plus)
  patch5 = rectangle(corner=(patchX/2-slot_width-starter_x_plus, patchY/2-starter_y_plus, subH), x_size=-patchX+2*slot_width+starter+starter_x_plus, y_size=-slot_width)
  implant1 [Rogers RO3210 (tm)] = box(corner=(-subX/2, -subY/2, subH1/2), size=(subX, subY, subH1/2))
  Sphere1 [humanbone_cortical] = sphere(centre=(0mm, 0mm, SubH), radius=muscleR)
  Gap_Xminus = rectangle(corner=(-patchX/2+starter, patchY/2-starter_y_plus-feed_off, subH1), x_size=-starter, y_size=-Gap*2-feed_width)
  feed = rectangle(corner=(-patchX/2, patchY/2-starter_y_plus-Gap-feed_off, subH1), x_size=starter+feed_enter*3, y_size=-feed_width)
  patch.subtract(Gap_Xminus)
  patch1_1 = patch1.copy()
  patch3_1 = patch3.copy()
  patch4_1 = patch4.copy()
  patch5_1 = patch5.copy()
  patch.subtract(patch1_1, patch3_1, patch4_1, patch5_1)
  implant1_ObjectFromFace1 = object_from(implant1.face(-z))
  Rectangle1 = rectangle(corner=(-patchX/2, patchY/2-starter_y_plus-feed_off, subH1/2), y_size=1mm, z_size=subH1/2)
  Rectangle2 = rectangle(corner=(-patchX/2, patchY/2-starter_y_plus-feed_off-2*Gap-feed_width, subH1/2), y_size=-1mm, z_size=subH1/2)
  Rectangle3 = rectangle(corner=(-patchX/2, patchY/2-starter_y_plus-feed_off, (subH1/6)*3), y_size=-2*Gap-feed_width, z_size=(subH1/6))
  patch.unite(Rectangle1, Rectangle3, Rectangle2, implant1_ObjectFromFace1)
  Rectangle4 = rectangle(corner=(-patchX/2, patchY/2-starter_y_plus-Gap-feed_off, subH1), y_size=-feed_width, z_size=-subH1/3)
  patch_Detach1 = patch.detach(patch.face(at (0.05, -0.05, 2)))
boundaries and excitations:
  PerfE1: Perfect E Objects=patch
  Feed: Perfect E Objects=feed
  orata: Perfect E Objects=patch_Detach1
  feed_T1: Terminal port=1 Edges=feed.edge(at (-7, 0.1, 2)) TerminalResistance=50ohm
  1: Lumped Port Faces=Rectangle4.face LumpedPortType=Terminal Impedance=50ohm
  reference conductors: feed, patch
setups:
  freq: HfssDriven Frequency=4GHz MaxDeltaS=0.01 MaximumPasses=20 MinimumPasses=1 MinimumConvergedPasses=1 PercentRefinement=30 BasisOrder=1 PortAccuracy=2 DrivenSolverType="Direct Solver" IESolverType=ACA
    sweep Sweep: point 0.7965GHz; Type=Discrete SaveFields
    sweep Sweep1: 0.1GHz to 9GHz, 5001 points; Type=Interpolating InterpTolerance=0.5 InterpMaxSolns=250 PassivityErrorTolerance=0.0001
source amplitudes:
  1:1: 1V 0deg
optimetrics:
  ParametricSetup1: Parametric
    sweep feedpos: LIN 0.5mm 1.5mm 0.1mm
  ParametricSetup2: Parametric Sim._Setups=[freq]
    sweep muscleR: LIN 20mm 60mm 10mm
output variables:
  eff = RadiatedPower/AcceptedPower
  emis_multiplicator = IncidentPower/AcceptedPower
reports:
  Terminal S Parameter Plot 1: dB(St(feed_T1,feed_T1)) vs Freq on freq : Sweep1

design cpw_er6_2 (HFSS, HFSS Terminal Network, model units mm)
options: Allow_Material_Override Save_Adaptive_support_files
variables:
  # Patch Dimensions
  patchX = 25mm
  patchY = patchX
  # Substrate Dimensions
  subH = subH1
  subX = patchX
  subY = patchY
  # Feed
  feed_length = 6mm
  # Air Box
  Airbox_dist = 50mm
  # Virtual Object Radiation Surface
  VirtualObject_dist = 2.9979mm
  subH1 = 3.2mm
  subH1_6 = 0mm
  subH1_8 = 0mm
  subH2 = 0mm
  subH2_5 = 0mm
  subH3 = 0mm
  subH4 = 0mm
  subH5 = 0mm
  subH7 = 0mm
  subH10 = 0mm
  slot_width = 2mm
  muscleZ = 90mm
  muscleZ_back = 10mm
  feed_width = 0.4mm
  x_extend = -3mm
  y_extend = 0.8mm
  x_pos = 0mm
  y_pos = 0mm
  muscleR = 90mm
  feedpos = 4mm
  starter = 2.5mm
  siliconR = 25mm
  starter_y_minus = 2.5mm
  starter_y_plus = 2.5mm
  starter_x_plus = 2.5m
  feed_off = feedpos
  Gap = 0.4mm
  lumped_feed_helper = 0.25mm
  feed_enter = 1.5m
  T_length = 3m
  T_width = 0.2mm
  Xkapat = -3m
  Ykapat = 3m
  Xkapat_size = 7m
  Ykapat_size = 3.75m
geometry:
  patch = rectangle(corner=(-patchX/2, -patchY/2, subH), x_size=patchX, y_size=patchY)
  AirBox [vacuum] = box(corner=(-muscleR/2 - Airbox_dist, -muscleR/2 - Airbox_dist, -muscleR/2- Airbox_dist), size=(muscleR + 2*Airbox_dist, muscleR + 2*Airbox_dist, muscleR + 2*Airbox_dist))
  implant2_5 [implant_2_5] = box(corner=(-subX/2, -subY/2, 0mm), size=(subX, subY, subH2_5*2))
  implant1_8 [implant_1_8] = box(corner=(-subX/2, -subY/2, 0mm), size=(subX, subY, subH1_8*2))
  implant10 [implant10] = box(corner=(-subX/2, -subY/2, 0mm), size=(subX, subY, subH10*2))
  implant7 [implant7] = box(corner=(-subX/2, -subY/2, 0mm), size=(subX, subY, subH7*2))
  implant5 [Implant5] = box(corner=(-subX/2, -subY/2, 0mm), size=(subX, subY, subH5*2))
  implant4 [implant4] = box(corner=(-subX/2, -subY/2, 0mm), size=(subX, subY, subH4*2))
  implant3 [implant3] = box(corner=(-subX/2, -subY/2, 0mm), size=(subX, subY, subH3*2))
  implant2 [implant2] = box(corner=(-subX/2, -subY/2, 0mm), size=(subX, subY, subH2*2))
  patch1 = rectangle(corner=(-patchX/2+starter, -patchY/2+starter_y_minus, subH), x_size=slot_width, y_size=patchY-starter_y_minus-starter_y_plus)
  patch3 = rectangle(corner=(-patchX/2+starter+slot_width, -patchY/2+starter_y_minus, subH), x_size=patchX-starter-slot_width-starter_x_plus, y_size=slot_width)
  patch4 = rectangle(corner=(patchX/2-starter_x_plus, -patchY/2+slot_width+starter_y_minus, subH), x_size=-slot_width, y_size=patchY-slot_width-starter_y_minus-starter_y_plus)
  patch5 = rectangle(corner=(patchX/2-slot_width-starter_x_plus, patchY/2-starter_y_plus, subH), x_size=-patchX+3*slot_width+starter+starter_x_plus, y_size=-slot_width)
  patch6 = rectangle(corner=(-patchX/2+starter+2*slot_width, -patchY/2+starter_y_minus+2*slot_width, subH), x_size=slot_width, y_size=patchY-3*slot_width-starter_y_plus-starter_y_minus)
  patch7 = rectangle(corner=(-patchX/2+3*slot_width+starter, -patchY/2+2*slot_width+starter_y_minus, subH), x_size=patchX-5*slot_width-starter-starter_x_plus, y_size=slot_width)
  implant1 [Rogers RT/duroid 6006 (tm)] = box(corner=(-subX/2-lumped_feed_helper*2, -subY/2, subH1/2), size=(subX+lumped_feed_helper*2, subY, subH1/2))
  implant1_6 [implant1_6] = box(corner=(-subX/2, -subY/2, 0mm), size=(subX, subY, subH1_6*2))
  Sphere1 [Material1, not solved inside] = sphere(centre=(0mm, 0mm, SubH), radius=muscleR)
  patch.subtract(patch1)
  patch.subtract(patch3..patch7)
  Sphere2 [silicon] = sphere(centre=(0mm, 0mm, SubH), radius=siliconR)
  Box2 = box(corner=(-muscler, -muscler, -40mm), size=(muscler*2, muscleR*2, -50mm))
  Sphere2.subtract(Box2)
  Sphere3 = sphere(centre=(0mm, 0mm, SubH), radius=siliconR)
  Box3 = box(corner=(-muscler, -muscler, -40mm), size=(muscler*2, muscleR*2, -50mm))
  Sphere3.subtract(Box3)
  Sphere1.subtract(Sphere3)
  patch8 = rectangle(corner=(patchX/2-starter_x_plus-slot_width*2, -patchY/2+starter_y_minus+slot_width*3, subH1), x_size=-slot_width, y_size=patchY-starter_y_plus-starter_y_minus-slot_width*5)
  patch.subtract(patch8)
  patch1_1 = rectangle(corner=(-patchX/2+starter, -patchY/2+starter_y_minus, subH), x_size=slot_width, y_size=patchY-starter_y_minus-starter_y_plus)
  patch3_1 = rectangle(corner=(-patchX/2+starter+slot_width, -patchY/2+starter_y_minus, subH), x_size=patchX-starter-slot_width-starter_x_plus, y_size=slot_width)
  patch4_1 = rectangle(corner=(patchX/2-starter_x_plus, -patchY/2+slot_width+starter_y_minus, subH), x_size=-slot_width, y_size=patchY-slot_width-starter_y_minus-starter_y_plus)
  patch5_1 = rectangle(corner=(patchX/2-slot_width-starter_x_plus, patchY/2-starter_y_plus, subH), x_size=-patchX+3*slot_width+starter+starter_x_plus, y_size=-slot_width)
  patch6_1 = rectangle(corner=(-patchX/2+starter+2*slot_width, -patchY/2+starter_y_minus+2*slot_width, subH), x_size=slot_width, y_size=patchY-3*slot_width-starter_y_plus-starter_y_minus)
  patch8_1 = rectangle(corner=(patchX/2-starter_x_plus-slot_width*2, -patchY/2+starter_y_minus+slot_width*3, subH1), x_size=-slot_width, y_size=patchY-starter_y_plus-starter_y_minus-slot_width*5)
  patch7_1 = rectangle(corner=(-patchX/2+3*slot_width+starter, -patchY/2+2*slot_width+starter_y_minus, subH), x_size=patchX-5*slot_width-starter-starter_x_plus, y_size=slot_width)
  Gap_Xminus = rectangle(corner=(-patchX/2+starter, patchY/2-starter_y_plus-feed_off, subH1), x_size=-starter, y_size=-Gap*2-feed_width)
  feed = rectangle(corner=(-patchX/2, patchY/2-starter_y_plus-Gap-feed_off, subH1), x_size=starter+feed_enter, y_size=-feed_width)
  patch.subtract(Gap_Xminus)
  lumped_port = rectangle(corner=(-patchX/2, patchY/2-starter_y_plus-feed_off-Gap, subH1), x_size=-lumped_feed_helper, y_size=-feed_width)
  feed_helper_substract = rectangle(corner=(-patchX/2, patchY/2-starter_y_plus-feed_off, subH1), x_size=-lumped_feed_helper, y_size=-Gap*2-feed_width)
  feed_connector = rectangle(corner=(-patchX/2, patchY/2, subH1), x_size=-lumped_feed_helper*2, y_size=-patchY)
  feed_connector.subtract(feed_helper_substract)
  patch.unite(feed_connector)
  feed_T = rectangle(corner=(-patchX/2+starter+feed_enter, patchY/2-starter_y_plus-feed_off-T_length/2-Gap-feed_width/2, subH1), x_size=T_width, y_size=T_length)
  patch9 = rectangle(corner=(patchX/2-starter_x_plus-3*slot_width, patchY/2-starter_y_plus-2*slot_width, subH1), x_size=-patchX+starter_x_plus+starter+7*slot_width, y_size=-slot_width)
  patch9_1 = rectangle(corner=(Xkapat, Ykapat, subH1), x_size=Xkapat_size, y_size=Ykapat_size)
  patch.subtract(patch9)
boundaries and excitations:
  Rad: Radiation Objects=AirBox
  patch: Perfect E Objects=patch
  PerfE1: Perfect E Objects=feed
  PerfE2: Perfect E Objects=feed_T
  kapatici: Perfect E Objects=patch9_1
  feed_T1: Terminal port=1 Edges=feed.edge(at (-12.5, 5.4, 3.2)) TerminalResistance=50ohm
  1: Lumped Port Faces=lumped_port.face LumpedPortType=Terminal Impedance=50ohm
  reference conductors: feed, patch
setups:
  freq: HfssDriven Frequency=4GHz MaxDeltaS=0.01 MaximumPasses=20 MinimumPasses=1 MinimumConvergedPasses=1 PercentRefinement=30 BasisOrder=1 PortAccuracy=2 DrivenSolverType="Direct Solver" IESolverType=ACA
    sweep Sweep1: 0.1GHz to 5GHz, 5001 points; Type=Interpolating InterpTolerance=0.5 InterpMaxSolns=250 PassivityErrorTolerance=0.0001
source amplitudes:
  1:1: 1V 0deg
optimetrics:
  ParametricSetup1: Parametric Sim._Setups=[freq]
    sweep feedpos: LIN 1mm 14mm 1mm
radiation setups:
  Infinite Sphere1: Infinite Sphere Theta=0deg..180deg step 10deg Phi=0deg..360deg step 10deg
output variables:
  eff = RadiatedPower/AcceptedPower
  emis_multiplicator = IncidentPower/AcceptedPower
reports:
  Terminal S Parameter Plot 1: dB(St(feed_T1,feed_T1)) vs Freq on freq : Sweep1 [muscleR=all feedpos=all]; markers m2 at 0.38812GHz

design cpw_er6_3 (HFSS, HFSS Terminal Network, model units mm)
options: Allow_Material_Override Save_Adaptive_support_files
variables:
  # Patch Dimensions
  patchX = 14mm
  patchY = patchX
  # Substrate Dimensions
  subH = subH1
  subX = patchX
  subY = patchY
  # Feed
  feed_length = 6mm
  # Air Box
  Airbox_dist = 50mm
  # Virtual Object Radiation Surface
  VirtualObject_dist = 2.9979mm
  subH1 = 3.2mm
  subH1_6 = 0mm
  subH1_8 = 0mm
  subH2 = 0mm
  subH2_5 = 0mm
  subH3 = 0mm
  subH4 = 0mm
  subH5 = 0mm
  subH7 = 0mm
  subH10 = 0mm
  slot_width = 0.75mm
  muscleZ = 90mm
  muscleZ_back = 10mm
  feed_width = 0.4mm
  x_extend = -3mm
  y_extend = 0.8mm
  x_pos = 0mm
  y_pos = 0mm
  muscleR = 90mm
  feedpos = 5mm
  starter = 2.6mm
  siliconR = 15mm
  starter_y_minus = 2.4mm
  starter_y_plus = 2.5mm
  starter_x_plus = 2.5m
  feed_off = 5m
  Gap = 0.4mm
  lumped_feed_helper = 0.25mm
  feed_enter = 0.4m
  T_length = 2m
  T_width = 0.2mm
geometry:
  patch = rectangle(corner=(-patchX/2, -patchY/2, subH), x_size=patchX, y_size=patchY)
  AirBox [vacuum] = box(corner=(-muscleR/2 - Airbox_dist, -muscleR/2 - Airbox_dist, -muscleR/2- Airbox_dist), size=(muscleR + 2*Airbox_dist, muscleR + 2*Airbox_dist, muscleR + 2*Airbox_dist))
  implant2_5 [implant_2_5] = box(corner=(-subX/2, -subY/2, 0mm), size=(subX, subY, subH2_5*2))
  implant1_8 [implant_1_8] = box(corner=(-subX/2, -subY/2, 0mm), size=(subX, subY, subH1_8*2))
  implant10 [implant10] = box(corner=(-subX/2, -subY/2, 0mm), size=(subX, subY, subH10*2))
  implant7 [implant7] = box(corner=(-subX/2, -subY/2, 0mm), size=(subX, subY, subH7*2))
  implant5 [Implant5] = box(corner=(-subX/2, -subY/2, 0mm), size=(subX, subY, subH5*2))
  implant4 [implant4] = box(corner=(-subX/2, -subY/2, 0mm), size=(subX, subY, subH4*2))
  implant3 [implant3] = box(corner=(-subX/2, -subY/2, 0mm), size=(subX, subY, subH3*2))
  implant2 [implant2] = box(corner=(-subX/2, -subY/2, 0mm), size=(subX, subY, subH2*2))
  patch1 = rectangle(corner=(-patchX/2+starter, -patchY/2+starter_y_minus, subH), x_size=slot_width, y_size=patchY-starter_y_minus-starter_y_plus)
  patch3 = rectangle(corner=(-patchX/2+starter+slot_width, -patchY/2+starter_y_minus, subH), x_size=patchX-starter-slot_width-starter_x_plus, y_size=slot_width)
  patch4 = rectangle(corner=(patchX/2-starter_x_plus, -patchY/2+slot_width+starter_y_minus, subH), x_size=-slot_width, y_size=patchY-slot_width-starter_y_minus-starter_y_plus)
  patch5 = rectangle(corner=(patchX/2-slot_width-starter_x_plus, patchY/2-starter_y_plus, subH), x_size=-patchX+3*slot_width+starter+starter_x_plus, y_size=-slot_width)
  patch6 = rectangle(corner=(-patchX/2+starter+2*slot_width, -patchY/2+starter_y_minus+2*slot_width, subH), x_size=slot_width, y_size=patchY-3*slot_width-starter_y_plus-starter_y_minus)
  patch7 = rectangle(corner=(-patchX/2+3*slot_width+starter, -patchY/2+2*slot_width+starter_y_minus, subH), x_size=patchX-5*slot_width-starter-starter_x_plus, y_size=slot_width)
  implant1 [Rogers RT/duroid 6006 (tm)] = box(corner=(-subX/2-lumped_feed_helper*2, -subY/2, subH1/2), size=(subX+lumped_feed_helper*2, subY, subH1/2))
  implant1_6 [implant1_6] = box(corner=(-subX/2, -subY/2, 0mm), size=(subX, subY, subH1_6*2))
  Sphere1 [Material1, not solved inside] = sphere(centre=(0mm, 0mm, SubH), radius=muscleR)
  patch.subtract(patch1)
  patch.subtract(patch3..patch7)
  Sphere2 [silicon] = sphere(centre=(0mm, 0mm, SubH), radius=siliconR)
  Box2 = box(corner=(-muscler, -muscler, -40mm), size=(muscler*2, muscleR*2, -50mm))
  Sphere2.subtract(Box2)
  Sphere3 = sphere(centre=(0mm, 0mm, SubH), radius=siliconR)
  Box3 = box(corner=(-muscler, -muscler, -40mm), size=(muscler*2, muscleR*2, -50mm))
  Sphere3.subtract(Box3)
  Sphere1.subtract(Sphere3)
  patch8 = rectangle(corner=(patchX/2-starter_x_plus-slot_width*2, -patchY/2+starter_y_minus+slot_width*3, subH1), x_size=-slot_width, y_size=patchY-starter_y_plus-starter_y_minus-slot_width*5)
  patch.subtract(patch8)
  patch1_1 = rectangle(corner=(-patchX/2+starter, -patchY/2+starter_y_minus, subH), x_size=slot_width, y_size=patchY-starter_y_minus-starter_y_plus)
  patch3_1 = rectangle(corner=(-patchX/2+starter+slot_width, -patchY/2+starter_y_minus, subH), x_size=patchX-starter-slot_width-starter_x_plus, y_size=slot_width)
  patch4_1 = rectangle(corner=(patchX/2-starter_x_plus, -patchY/2+slot_width+starter_y_minus, subH), x_size=-slot_width, y_size=patchY-slot_width-starter_y_minus-starter_y_plus)
  patch5_1 = rectangle(corner=(patchX/2-slot_width-starter_x_plus, patchY/2-starter_y_plus, subH), x_size=-patchX+3*slot_width+starter+starter_x_plus, y_size=-slot_width)
  patch6_1 = rectangle(corner=(-patchX/2+starter+2*slot_width, -patchY/2+starter_y_minus+2*slot_width, subH), x_size=slot_width, y_size=patchY-3*slot_width-starter_y_plus-starter_y_minus)
  patch8_1 = rectangle(corner=(patchX/2-starter_x_plus-slot_width*2, -patchY/2+starter_y_minus+slot_width*3, subH1), x_size=-slot_width, y_size=patchY-starter_y_plus-starter_y_minus-slot_width*5)
  patch7_1 = rectangle(corner=(-patchX/2+3*slot_width+starter, -patchY/2+2*slot_width+starter_y_minus, subH), x_size=patchX-5*slot_width-starter-starter_x_plus, y_size=slot_width)
  Gap_Xminus = rectangle(corner=(-patchX/2+starter, patchY/2-starter_y_plus-feed_off, subH1), x_size=-starter, y_size=-Gap*2-feed_width)
  feed = rectangle(corner=(-patchX/2, patchY/2-starter_y_plus-Gap-feed_off, subH1), x_size=starter+feed_enter, y_size=-feed_width)
  patch.subtract(Gap_Xminus)
  lumped_port = rectangle(corner=(-patchX/2, patchY/2-starter_y_plus-feed_off-Gap, subH1), x_size=-lumped_feed_helper, y_size=-feed_width)
  feed_helper_substract = rectangle(corner=(-patchX/2, patchY/2-starter_y_plus-feed_off, subH1), x_size=-lumped_feed_helper, y_size=-Gap*2-feed_width)
  feed_connector = rectangle(corner=(-patchX/2, patchY/2, subH1), x_size=-lumped_feed_helper*2, y_size=-patchY)
  feed_connector.subtract(feed_helper_substract)
  patch.unite(feed_connector)
  feed_T = rectangle(corner=(-patchX/2+starter+feed_enter, patchY/2-starter_y_plus-feed_off-T_length/2-Gap-feed_width/2, subH1), x_size=T_width, y_size=T_length)
boundaries and excitations:
  Rad: Radiation Objects=AirBox
  patch: Perfect E Objects=patch
  PerfE1: Perfect E Objects=feed
  PerfE2: Perfect E Objects=feed_T
  PerfE3: Perfect E Objects=patch8_1
  PerfE4: Perfect E Objects=patch7_1
  feed_T1: Terminal port=1 Edges=feed.edge(at (-7, -1.1, 3.2)) TerminalResistance=50ohm
  1: Lumped Port Faces=lumped_port.face LumpedPortType=Terminal Impedance=50ohm
  reference conductors: feed, patch
setups:
  freq: HfssDriven Frequency=4GHz MaxDeltaS=0.01 MaximumPasses=20 MinimumPasses=1 MinimumConvergedPasses=1 PercentRefinement=30 BasisOrder=1 PortAccuracy=2 DrivenSolverType="Direct Solver" IESolverType=ACA
    sweep single: point 0.7965GHz; Type=Discrete SaveFields
    sweep Sweep1: 0.1GHz to 4GHz, 5001 points; Type=Interpolating InterpTolerance=0.5 InterpMaxSolns=250 PassivityErrorTolerance=0.0001
    sweep single1: point 0.8839GHz; Type=Discrete SaveFields
    sweep single2: point 1.0282GHz; Type=Discrete SaveFields
source amplitudes:
  1:1: 1V 0deg
optimetrics:
  ParametricSetup1: Parametric
  ParametricSetup2: Parametric
    sweep muscleR: LIN 20mm 60mm 10mm
radiation setups:
  Infinite Sphere1: Infinite Sphere Theta=0deg..180deg step 10deg Phi=0deg..360deg step 10deg
output variables:
  eff = RadiatedPower/AcceptedPower
  emis_multiplicator = IncidentPower/AcceptedPower
reports:
  Terminal S Parameter Plot 1: dB(St(feed_T1,feed_T1)) vs Freq on freq : Sweep1 [muscleR=all]; dB(St(feed_T1,feed_T1)) vs Freq on freq : single [muscleR=all]; dB(St(feed_T1,feed_T1)) vs Freq on freq : single1 [muscleR=all]; dB(St(feed_T1,feed_T1)) vs Freq on freq : single2 [muscleR=all]

design cpw_er6_4 (HFSS, HFSS Terminal Network, model units mm)
options: Allow_Material_Override Save_Adaptive_support_files
variables:
  # Patch Dimensions
  patchX = 14mm
  patchY = 14mm
  # Substrate Dimensions
  subH = subH1
  subX = patchX
  subY = patchY
  # Feed
  feed_length = 6mm
  # Air Box
  Airbox_dist = 50mm
  # Virtual Object Radiation Surface
  VirtualObject_dist = 2.9979mm
  subH1 = 3.2mm
  subH1_6 = 0mm
  subH1_8 = 0mm
  subH2 = 0mm
  subH2_5 = 0mm
  subH3 = 0mm
  subH4 = 0mm
  subH5 = 0mm
  subH7 = 0mm
  subH10 = 0mm
  slot_width = 0.75mm
  muscleZ = 90mm
  muscleZ_back = 10mm
  feed_width = 0.4mm
  x_extend = -3mm
  y_extend = 0.8mm
  x_pos = 0mm
  y_pos = 0mm
  muscleR = 90mm
  feedpos = 4mm
  starter = 2.5mm
  siliconR = 15mm
  starter_y_minus = 2.5mm
  starter_y_plus = 2.5mm
  starter_x_plus = 2.5m
  feed_off = feedpos
  Gap = 0.4mm
  lumped_feed_helper = 0.25mm
  feed_enter = 0.25m
  T_length = 2m
  T_width = 0.2mm
geometry:
  patch = rectangle(corner=(-patchX/2, -patchY/2, subH), x_size=patchX, y_size=patchY)
  AirBox [vacuum] = box(corner=(-muscleR/2 - Airbox_dist, -muscleR/2 - Airbox_dist, -muscleR/2- Airbox_dist), size=(muscleR + 2*Airbox_dist, muscleR + 2*Airbox_dist, muscleR + 2*Airbox_dist))
  implant2_5 [implant_2_5] = box(corner=(-subX/2, -subY/2, 0mm), size=(subX, subY, subH2_5*2))
  implant1_8 [implant_1_8] = box(corner=(-subX/2, -subY/2, 0mm), size=(subX, subY, subH1_8*2))
  implant10 [implant10] = box(corner=(-subX/2, -subY/2, 0mm), size=(subX, subY, subH10*2))
  implant7 [implant7] = box(corner=(-subX/2, -subY/2, 0mm), size=(subX, subY, subH7*2))
  implant5 [Implant5] = box(corner=(-subX/2, -subY/2, 0mm), size=(subX, subY, subH5*2))
  implant4 [implant4] = box(corner=(-subX/2, -subY/2, 0mm), size=(subX, subY, subH4*2))
  implant3 [implant3] = box(corner=(-subX/2, -subY/2, 0mm), size=(subX, subY, subH3*2))
  implant2 [implant2] = box(corner=(-subX/2, -subY/2, 0mm), size=(subX, subY, subH2*2))
  patch1 = rectangle(corner=(-patchX/2+starter, -patchY/2+starter_y_minus, subH), x_size=slot_width, y_size=patchY-starter_y_minus-starter_y_plus)
  patch3 = rectangle(corner=(-patchX/2+starter+slot_width, -patchY/2+starter_y_minus, subH), x_size=patchX-starter-slot_width-starter_x_plus, y_size=slot_width)
  patch4 = rectangle(corner=(patchX/2-starter_x_plus, -patchY/2+slot_width+starter_y_minus, subH), x_size=-slot_width, y_size=patchY-slot_width-starter_y_minus-starter_y_plus)
  patch5 = rectangle(corner=(patchX/2-slot_width-starter_x_plus, patchY/2-starter_y_plus, subH), x_size=-patchX+3*slot_width+starter+starter_x_plus, y_size=-slot_width)
  patch6 = rectangle(corner=(-patchX/2+starter+2*slot_width, -patchY/2+starter_y_minus+2*slot_width, subH), x_size=slot_width, y_size=patchY-3*slot_width-starter_y_plus-starter_y_minus)
  patch7 = rectangle(corner=(-patchX/2+3*slot_width+starter, -patchY/2+2*slot_width+starter_y_minus, subH), x_size=patchX-5*slot_width-starter-starter_x_plus, y_size=slot_width)
  implant1 [Rogers RT/duroid 6006 (tm)] = box(corner=(-subX/2-lumped_feed_helper*2, -subY/2, subH1/2), size=(subX+lumped_feed_helper*2, subY, subH1/2))
  implant1_6 [implant1_6] = box(corner=(-subX/2, -subY/2, 0mm), size=(subX, subY, subH1_6*2))
  Sphere1 [Material1, not solved inside] = sphere(centre=(0mm, 0mm, SubH), radius=muscleR)
  patch.subtract(patch1)
  patch.subtract(patch3..patch7)
  Sphere2 [silicon] = sphere(centre=(0mm, 0mm, SubH), radius=siliconR)
  Box2 = box(corner=(-muscler, -muscler, -40mm), size=(muscler*2, muscleR*2, -50mm))
  Sphere2.subtract(Box2)
  Sphere3 = sphere(centre=(0mm, 0mm, SubH), radius=siliconR)
  Box3 = box(corner=(-muscler, -muscler, -40mm), size=(muscler*2, muscleR*2, -50mm))
  Sphere3.subtract(Box3)
  Sphere1.subtract(Sphere3)
  patch8 = rectangle(corner=(patchX/2-starter_x_plus-slot_width*2, -patchY/2+starter_y_minus+slot_width*3, subH1), x_size=-slot_width, y_size=patchY-starter_y_plus-starter_y_minus-slot_width*5)
  patch.subtract(patch8)
  patch1_1 = rectangle(corner=(-patchX/2+starter, -patchY/2+starter_y_minus, subH), x_size=slot_width, y_size=patchY-starter_y_minus-starter_y_plus)
  patch3_1 = rectangle(corner=(-patchX/2+starter+slot_width, -patchY/2+starter_y_minus, subH), x_size=patchX-starter-slot_width-starter_x_plus, y_size=slot_width)
  patch4_1 = rectangle(corner=(patchX/2-starter_x_plus, -patchY/2+slot_width+starter_y_minus, subH), x_size=-slot_width, y_size=patchY-slot_width-starter_y_minus-starter_y_plus)
  patch5_1 = rectangle(corner=(patchX/2-slot_width-starter_x_plus, patchY/2-starter_y_plus, subH), x_size=-patchX+3*slot_width+starter+starter_x_plus, y_size=-slot_width)
  patch6_1 = rectangle(corner=(-patchX/2+starter+2*slot_width, -patchY/2+starter_y_minus+2*slot_width, subH), x_size=slot_width, y_size=patchY-3*slot_width-starter_y_plus-starter_y_minus)
  patch8_1 = rectangle(corner=(patchX/2-starter_x_plus-slot_width*2, -patchY/2+starter_y_minus+slot_width*3, subH1), x_size=-slot_width, y_size=patchY-starter_y_plus-starter_y_minus-slot_width*5)
  patch7_1 = rectangle(corner=(-patchX/2+3*slot_width+starter, -patchY/2+2*slot_width+starter_y_minus, subH), x_size=patchX-5*slot_width-starter-starter_x_plus, y_size=slot_width)
  Gap_Xminus = rectangle(corner=(-patchX/2+starter, patchY/2-starter_y_plus-feed_off, subH1), x_size=-starter, y_size=-Gap*2-feed_width)
  feed = rectangle(corner=(-patchX/2, patchY/2-starter_y_plus-Gap-feed_off, subH1), x_size=starter+feed_enter, y_size=-feed_width)
  patch.subtract(Gap_Xminus)
  lumped_port = rectangle(corner=(-patchX/2, patchY/2-starter_y_plus-feed_off-Gap, subH1), x_size=-lumped_feed_helper, y_size=-feed_width)
  feed_helper_substract = rectangle(corner=(-patchX/2, patchY/2-starter_y_plus-feed_off, subH1), x_size=-lumped_feed_helper, y_size=-Gap*2-feed_width)
  feed_connector = rectangle(corner=(-patchX/2, patchY/2, subH1), x_size=-lumped_feed_helper*2, y_size=-patchY)
  feed_connector.subtract(feed_helper_substract)
  patch.unite(feed_connector)
  feed_T = rectangle(corner=(-patchX/2+starter+feed_enter, patchY/2-starter_y_plus-feed_off-T_length/2-Gap-feed_width/2, subH1), x_size=T_width, y_size=T_length)
boundaries and excitations:
  Rad: Radiation Objects=AirBox
  patch: Perfect E Objects=patch
  PerfE1: Perfect E Objects=feed
  PerfE2: Perfect E Objects=feed_T
  PerfE3: Perfect E Objects=patch8_1
  PerfE4: Perfect E Objects=patch7_1
  PerfE5: Perfect E Objects=patch6_1
  PerfE6: Perfect E Objects=patch5_1
  PerfE7: Perfect E Objects=patch4_1
  PerfE8: Perfect E Objects=patch3_1
  feed_T1: Terminal port=1 Edges=feed.edge(at (-7, -0.1, 3.2)) TerminalResistance=50ohm
  1: Lumped Port Faces=lumped_port.face LumpedPortType=Terminal Impedance=50ohm
  reference conductors: feed, patch
setups:
  freq: HfssDriven Frequency=4GHz MaxDeltaS=0.01 MaximumPasses=20 MinimumPasses=1 MinimumConvergedPasses=1 PercentRefinement=30 BasisOrder=1 PortAccuracy=2 DrivenSolverType="Direct Solver" IESolverType=ACA
    sweep single: point 0.7965GHz; Type=Discrete SaveFields
    sweep Sweep1: 0.1GHz to 4GHz, 5001 points; Type=Interpolating InterpTolerance=0.5 InterpMaxSolns=250 PassivityErrorTolerance=0.0001
    sweep single1: point 0.8839GHz; Type=Discrete SaveFields
    sweep single2: point 1.0282GHz; Type=Discrete SaveFields
    sweep single3: point 1.3987GHz; Type=Discrete SaveFields
  freq1: HfssDriven Frequency=4GHz MaxDeltaS=0.01 MaximumPasses=20 MinimumPasses=1 MinimumConvergedPasses=1 PercentRefinement=30 BasisOrder=1 PortAccuracy=2 DrivenSolverType="Direct Solver" IESolverType=ACA
    sweep Sweep1: 0.1GHz to 4GHz, 5001 points; Type=Interpolating InterpTolerance=0.5 InterpMaxSolns=250 PassivityErrorTolerance=0.0001
source amplitudes:
  1:1: 1V 0deg
optimetrics:
  ParametricSetup1: Parametric Sim._Setups=[freq1]
    sweep feedpos: LIN 0.5mm 4mm 0.5mm
radiation setups:
  Infinite Sphere1: Infinite Sphere Theta=0deg..180deg step 10deg Phi=0deg..360deg step 10deg
output variables:
  eff = RadiatedPower/AcceptedPower
  emis_multiplicator = IncidentPower/AcceptedPower
reports:
  Terminal S Parameter Plot 1: dB(St(feed_T1,feed_T1)) vs Freq on freq1 : Sweep1; markers m1 at 3.298GHz

design cpw_er6_4_2 (HFSS, HFSS Terminal Network, model units mm)
options: Allow_Material_Override Save_Adaptive_support_files
variables:
  # Patch Dimensions
  patchX = 14mm
  patchY = patchX
  # Substrate Dimensions
  subH = subH1
  subX = patchX
  subY = patchY
  # Feed
  feed_length = 6mm
  # Air Box
  Airbox_dist = 50mm
  # Virtual Object Radiation Surface
  VirtualObject_dist = 2.9979mm
  subH1 = 3.2mm
  subH1_6 = 0mm
  subH1_8 = 0mm
  subH2 = 0mm
  subH2_5 = 0mm
  subH3 = 0mm
  subH4 = 0mm
  subH5 = 0mm
  subH7 = 0mm
  subH10 = 0mm
  slot_width = 0.5mm
  muscleZ = 90mm
  muscleZ_back = 10mm
  feed_width = 0.4mm
  x_extend = -3mm
  y_extend = 0.8mm
  x_pos = 0mm
  y_pos = 0mm
  muscleR = 90mm
  feedpos = 1.2mm
  starter = 2.6mm
  siliconR = 15mm
  starter_y_minus = 2.4mm
  starter_y_plus = 2.5mm
  starter_x_plus = 2.5m
  feed_off = 3m
  Gap = 0.4mm
  lumped_feed_helper = 0.25mm
  feed_enter = 0.4m
  T_length = 2m
  T_width = 0.2mm
  shrinker = 0mm
geometry:
  patch = rectangle(corner=(-patchX/2, -patchY/2, subH), x_size=patchX, y_size=patchY)
  AirBox [vacuum] = box(corner=(-muscleR/2 - Airbox_dist, -muscleR/2 - Airbox_dist, -muscleR/2- Airbox_dist), size=(muscleR + 2*Airbox_dist, muscleR + 2*Airbox_dist, muscleR + 2*Airbox_dist))
  implant2_5 [implant_2_5] = box(corner=(-subX/2, -subY/2, 0mm), size=(subX, subY, subH2_5*2))
  implant1_8 [implant_1_8] = box(corner=(-subX/2, -subY/2, 0mm), size=(subX, subY, subH1_8*2))
  implant10 [implant10] = box(corner=(-subX/2, -subY/2, 0mm), size=(subX, subY, subH10*2))
  implant7 [implant7] = box(corner=(-subX/2, -subY/2, 0mm), size=(subX, subY, subH7*2))
  implant5 [Implant5] = box(corner=(-subX/2, -subY/2, 0mm), size=(subX, subY, subH5*2))
  implant4 [implant4] = box(corner=(-subX/2, -subY/2, 0mm), size=(subX, subY, subH4*2))
  implant3 [implant3] = box(corner=(-subX/2, -subY/2, 0mm), size=(subX, subY, subH3*2))
  implant2 [implant2] = box(corner=(-subX/2, -subY/2, 0mm), size=(subX, subY, subH2*2))
  patch1 = rectangle(corner=(-patchX/2+starter, -patchY/2+starter_y_minus, subH), x_size=slot_width, y_size=patchY-starter_y_minus-starter_y_plus)
  patch3 = rectangle(corner=(-patchX/2+starter+slot_width, -patchY/2+starter_y_minus, subH), x_size=patchX-starter-slot_width-starter_x_plus, y_size=slot_width)
  patch4 = rectangle(corner=(patchX/2-starter_x_plus, -patchY/2+slot_width+starter_y_minus, subH), x_size=-slot_width, y_size=patchY-slot_width-starter_y_minus-starter_y_plus)
  patch5 = rectangle(corner=(patchX/2-slot_width-starter_x_plus, patchY/2-starter_y_plus, subH), x_size=-patchX+3*slot_width+starter+starter_x_plus, y_size=-slot_width)
  patch6 = rectangle(corner=(-patchX/2+starter+2*slot_width, -patchY/2+starter_y_minus+2*slot_width, subH), x_size=slot_width, y_size=patchY-3*slot_width-starter_y_plus-starter_y_minus)
  patch7 = rectangle(corner=(-patchX/2+3*slot_width+starter, -patchY/2+2*slot_width+starter_y_minus, subH), x_size=patchX-5*slot_width-starter-starter_x_plus, y_size=slot_width)
  implant1 [Rogers RT/duroid 6006 (tm)] = box(corner=(-subX/2-lumped_feed_helper*2, -subY/2, subH1/2), size=(subX+lumped_feed_helper*2, subY, subH1/2))
  implant1_6 [implant1_6] = box(corner=(-subX/2, -subY/2, 0mm), size=(subX, subY, subH1_6*2))
  Sphere1 [Material1, not solved inside] = sphere(centre=(0mm, 0mm, SubH), radius=muscleR)
  patch.subtract(patch1)
  patch.subtract(patch3..patch7)
  Sphere2 [silicon] = sphere(centre=(0mm, 0mm, SubH), radius=siliconR)
  Box2 = box(corner=(-muscler, -muscler, -40mm), size=(muscler*2, muscleR*2, -50mm))
  Sphere2.subtract(Box2)
  Sphere3 = sphere(centre=(0mm, 0mm, SubH), radius=siliconR)
  Box3 = box(corner=(-muscler, -muscler, -40mm), size=(muscler*2, muscleR*2, -50mm))
  Sphere3.subtract(Box3)
  Sphere1.subtract(Sphere3)
  patch8 = rectangle(corner=(patchX/2-starter_x_plus-slot_width*2, -patchY/2+starter_y_minus+slot_width*3, subH1), x_size=-slot_width, y_size=patchY-starter_y_plus-starter_y_minus-slot_width*5)
  patch.subtract(patch8)
  patch1_1 = rectangle(corner=(-patchX/2+starter, -patchY/2+starter_y_minus, subH), x_size=slot_width, y_size=patchY-starter_y_minus-starter_y_plus)
  patch3_1 = rectangle(corner=(-patchX/2+starter+slot_width, -patchY/2+starter_y_minus, subH), x_size=patchX-starter-slot_width-starter_x_plus, y_size=slot_width)
  patch4_1 = rectangle(corner=(patchX/2-starter_x_plus, -patchY/2+slot_width+starter_y_minus, subH), x_size=-slot_width, y_size=patchY-slot_width-starter_y_minus-starter_y_plus)
  patch5_1 = rectangle(corner=(patchX/2-slot_width-starter_x_plus, patchY/2-starter_y_plus, subH), x_size=-patchX+3*slot_width+starter+starter_x_plus, y_size=-slot_width)
  patch6_1 = rectangle(corner=(-patchX/2+starter+2*slot_width, -patchY/2+starter_y_minus+2*slot_width, subH), x_size=slot_width, y_size=patchY-3*slot_width-starter_y_plus-starter_y_minus-shrinker)
  patch8_1 = rectangle(corner=(patchX/2-starter_x_plus-slot_width*2, -patchY/2+starter_y_minus+slot_width*3, subH1), x_size=-slot_width, y_size=patchY-starter_y_plus-starter_y_minus-slot_width*5)
  patch7_1 = rectangle(corner=(-patchX/2+3*slot_width+starter, -patchY/2+2*slot_width+starter_y_minus, subH), x_size=patchX-5*slot_width-starter-starter_x_plus, y_size=slot_width)
  Gap_Xminus = rectangle(corner=(-patchX/2+starter, patchY/2-starter_y_plus-feed_off, subH1), x_size=-starter, y_size=-Gap*2-feed_width)
  feed = rectangle(corner=(-patchX/2, patchY/2-starter_y_plus-Gap-feed_off, subH1), x_size=starter+feed_enter, y_size=-feed_width)
  patch.subtract(Gap_Xminus)
  lumped_port = rectangle(corner=(-patchX/2, patchY/2-starter_y_plus-feed_off-Gap, subH1), x_size=-lumped_feed_helper, y_size=-feed_width)
  feed_helper_substract = rectangle(corner=(-patchX/2, patchY/2-starter_y_plus-feed_off, subH1), x_size=-lumped_feed_helper, y_size=-Gap*2-feed_width)
  feed_connector = rectangle(corner=(-patchX/2, patchY/2, subH1), x_size=-lumped_feed_helper*2, y_size=-patchY)
  feed_connector.subtract(feed_helper_substract)
  patch.unite(feed_connector)
  feed_T = rectangle(corner=(-patchX/2+starter+feed_enter, patchY/2-starter_y_plus-feed_off-T_length/2-Gap-feed_width/2, subH1), x_size=T_width, y_size=T_length)
boundaries and excitations:
  Rad: Radiation Objects=AirBox
  patch: Perfect E Objects=patch
  PerfE1: Perfect E Objects=feed
  PerfE2: Perfect E Objects=feed_T
  PerfE3: Perfect E Objects=patch8_1
  PerfE4: Perfect E Objects=patch7_1
  PerfE5: Perfect E Objects=patch6_1
  feed_T1: Terminal port=1 Edges=feed.edge(at (-7, 0.9, 3.2)) TerminalResistance=50ohm
  1: Lumped Port Faces=lumped_port.face LumpedPortType=Terminal Impedance=50ohm
  reference conductors: feed, patch
setups:
  freq: HfssDriven Frequency=4GHz MaxDeltaS=0.01 MaximumPasses=20 MinimumPasses=1 MinimumConvergedPasses=1 PercentRefinement=30 BasisOrder=1 PortAccuracy=2 DrivenSolverType="Direct Solver" IESolverType=ACA
    sweep single: point 0.7965GHz; Type=Discrete SaveFields
    sweep Sweep1: 0.1GHz to 4GHz, 5001 points; Type=Interpolating InterpTolerance=0.5 InterpMaxSolns=250 PassivityErrorTolerance=0.0001
    sweep single1: point 0.8839GHz; Type=Discrete SaveFields
    sweep single2: point 1.0282GHz; Type=Discrete SaveFields
  freq1: HfssDriven Frequency=4GHz MaxDeltaS=0.01 MaximumPasses=20 MinimumPasses=1 MinimumConvergedPasses=1 PercentRefinement=30 BasisOrder=1 PortAccuracy=2 DrivenSolverType="Direct Solver" IESolverType=ACA
    sweep Sweep1: 0.1GHz to 4GHz, 5001 points; Type=Interpolating InterpTolerance=0.5 InterpMaxSolns=250 PassivityErrorTolerance=0.0001
source amplitudes:
  1:1: 1V 0deg
optimetrics:
  ParametricSetup1: Parametric Sim._Setups=[freq1]
    sweep shrinker: LIN 0mm 4mm 1mm
radiation setups:
  Infinite Sphere1: Infinite Sphere Theta=0deg..180deg step 10deg Phi=0deg..360deg step 10deg
output variables:
  eff = RadiatedPower/AcceptedPower
  emis_multiplicator = IncidentPower/AcceptedPower
reports:
  Terminal S Parameter Plot 2: dB(St(feed_T1,feed_T1)) vs Freq on freq1 : Sweep1

design ImplantSimplyfyB_aydin (HFSS, HFSS Terminal Network, model units mm)
options: Allow_Material_Override Save_Adaptive_support_files
variables:
  # Patch Dimensions
  patchX = 14mm
  patchY = patchX
  # Substrate Dimensions
  subH = subH1
  subX = patchX
  subY = patchY
  # Feed
  feed_length = 6mm
  # Air Box
  Airbox_dist = 50mm
  # Virtual Object Radiation Surface
  VirtualObject_dist = 2.9979mm
  subH1 = 2mm
  subH1_6 = 0mm
  subH1_8 = 0mm
  subH2 = 0mm
  subH2_5 = 0mm
  subH3 = 0mm
  subH4 = 0mm
  subH5 = 0mm
  subH7 = 0mm
  subH10 = 0mm
  slot_width = 0.1mm
  muscleZ = 90mm
  muscleZ_back = 10mm
  feed_width = 0.8mm
  x_extend = -3mm
  y_extend = 0.8mm
  x_pos = 0mm
  y_pos = 0mm
  muscleR = 20mm
  feedpos = 1.2mm
  starter = 2.6mm
  siliconR = 15mm
  starter_y_minus = 2.4mm
  starter_y_plus = 2.5mm
  starter_x_plus = 2.5m
  feed_off = 3m
  Gap = 1mm
  lumped_feed_helper = 0.25mm
  feed_enter = 0.4m
  T_length = 2m
  T_width = 0.2mm
geometry:
  patch = rectangle(corner=(-patchX/2, -patchY/2, subH), x_size=patchX, y_size=patchY)
  AirBox [vacuum] = box(corner=(-muscleR/2 - Airbox_dist, -muscleR/2 - Airbox_dist, -muscleR/2- Airbox_dist), size=(muscleR + 2*Airbox_dist, muscleR + 2*Airbox_dist, muscleR + 2*Airbox_dist))
  patch1 = rectangle(corner=(-patchX/2+starter, -patchY/2+starter_y_minus, subH), x_size=slot_width, y_size=patchY-starter_y_minus-starter_y_plus)
  patch3 = rectangle(corner=(-patchX/2+starter+slot_width, -patchY/2+starter_y_minus, subH), x_size=patchX-starter-slot_width-starter_x_plus, y_size=slot_width)
  patch4 = rectangle(corner=(patchX/2-starter_x_plus, -patchY/2+slot_width+starter_y_minus, subH), x_size=-slot_width, y_size=patchY-slot_width-starter_y_minus-starter_y_plus)
  patch5 = rectangle(corner=(patchX/2-slot_width-starter_x_plus, patchY/2-starter_y_plus, subH), x_size=-patchX+2*slot_width+starter+starter_x_plus, y_size=-slot_width)
  implant1 [Rogers RO3210 (tm)] = box(corner=(-subX/2, -subY/2, subH1/2), size=(subX, subY, subH1/2))
  Sphere1 [humanbone_cortical] = sphere(centre=(0mm, 0mm, SubH), radius=muscleR)
  Gap_Xminus = rectangle(corner=(-patchX/2+starter, patchY/2-starter_y_plus-feed_off, subH1), x_size=-starter, y_size=-Gap*2-feed_width)
  feed = rectangle(corner=(-patchX/2, patchY/2-starter_y_plus-Gap-feed_off, subH1), x_size=starter+feed_enter*3, y_size=-feed_width)
  patch.subtract(Gap_Xminus)
  patch1_1 = patch1.copy()
  patch3_1 = patch3.copy()
  patch4_1 = patch4.copy()
  patch5_1 = patch5.copy()
  patch.subtract(patch1_1, patch3_1, patch4_1, patch5_1)
  implant1_ObjectFromFace1 = object_from(implant1.face(-z))
  Rectangle1 = rectangle(corner=(-patchX/2, patchY/2-starter_y_plus-feed_off, subH1/2), y_size=1mm, z_size=subH1/2)
  Rectangle2 = rectangle(corner=(-patchX/2, patchY/2-starter_y_plus-feed_off-2*Gap-feed_width, subH1/2), y_size=-1mm, z_size=subH1/2)
  Rectangle3 = rectangle(corner=(-patchX/2, patchY/2-starter_y_plus-feed_off, (subH1/6)*3), y_size=-2*Gap-feed_width, z_size=(subH1/6))
  patch.unite(Rectangle1, Rectangle3, Rectangle2, implant1_ObjectFromFace1)
  Rectangle4 = rectangle(corner=(-patchX/2, patchY/2-starter_y_plus-Gap-feed_off, subH1), y_size=-feed_width, z_size=-subH1/3)
  patch_Detach1 = patch.detach(patch.face(at (0.05, -0.05, 2)))
  implant_extract = box(corner=(-subX/2, -subY/2, subH1/2), size=(subX, subY, subH1/2))
  feed_extract = rectangle(corner=(-patchX/2, patchY/2-starter_y_plus-Gap-feed_off, subH1), x_size=starter+feed_enter*3, y_size=-feed_width)
  patch6 = rectangle(corner=(-patchX/2, -patchY/2, subH), x_size=patchX, y_size=patchY)
  Gap_Xminus1 = rectangle(corner=(-patchX/2+starter, patchY/2-starter_y_plus-feed_off, subH1), x_size=-starter, y_size=-Gap*2-feed_width)
  patch6.subtract(Gap_Xminus1)
  patch7 = rectangle(corner=(-patchX/2+starter, -patchY/2+starter_y_minus, subH), x_size=slot_width, y_size=patchY-starter_y_minus-starter_y_plus)
  patch1_2 = patch7.copy()
  patch8 = rectangle(corner=(-patchX/2+starter+slot_width, -patchY/2+starter_y_minus, subH), x_size=patchX-starter-slot_width-starter_x_plus, y_size=slot_width)
  patch3_2 = patch8.copy()
  patch9 = rectangle(corner=(patchX/2-starter_x_plus, -patchY/2+slot_width+starter_y_minus, subH), x_size=-slot_width, y_size=patchY-slot_width-starter_y_minus-starter_y_plus)
  patch4_2 = patch9.copy()
  patch10 = rectangle(corner=(patchX/2-slot_width-starter_x_plus, patchY/2-starter_y_plus, subH), x_size=-patchX+2*slot_width+starter+starter_x_plus, y_size=-slot_width)
  patch5_2 = patch10.copy()
  patch6.subtract(patch1_2, patch3_2, patch4_2, patch5_2)
  Rectangle5 = rectangle(corner=(-patchX/2, patchY/2-starter_y_plus-feed_off, subH1/2), y_size=1mm, z_size=subH1/2)
  Rectangle7 = rectangle(corner=(-patchX/2, patchY/2-starter_y_plus-feed_off, (subH1/6)*3), y_size=-2*Gap-feed_width, z_size=(subH1/6))
  Rectangle6 = rectangle(corner=(-patchX/2, patchY/2-starter_y_plus-feed_off-2*Gap-feed_width, subH1/2), y_size=-1mm, z_size=subH1/2)
  implant2 = box(corner=(-subX/2, -subY/2, subH1/2), size=(subX, subY, subH1/2))
  implant1_ObjectFromFace2 = object_from(implant2.face(-z))
  patch6.unite(Rectangle5, Rectangle7, Rectangle6, implant1_ObjectFromFace2)
  patch_Detach2 = patch6.detach(feed_extract.face(at (0.05, -0.05, 2)))
  feed_extract.unite(patch6, patch_Detach2)
  [patch7..patch10, implant2].delete()
  patch_extract = rectangle(corner=(-patchX/2+starter, -patchY/2+starter_y_minus, subH), x_size=slot_width, y_size=patchY-starter_y_minus-starter_y_plus)
  patch12 = rectangle(corner=(-patchX/2+starter+slot_width, -patchY/2+starter_y_minus, subH), x_size=patchX-starter-slot_width-starter_x_plus, y_size=slot_width)
  patch13 = rectangle(corner=(patchX/2-starter_x_plus, -patchY/2+slot_width+starter_y_minus, subH), x_size=-slot_width, y_size=patchY-slot_width-starter_y_minus-starter_y_plus)
  patch14 = rectangle(corner=(patchX/2-slot_width-starter_x_plus, patchY/2-starter_y_plus, subH), x_size=-patchX+2*slot_width+starter+starter_x_plus, y_size=-slot_width)
  patch_extract.unite(patch12, patch13, patch14)
  Sphere1.subtract(feed_extract, implant_extract, patch_extract)
boundaries and excitations:
  Feed: Perfect E Objects=feed
  PerfE1: Perfect E Objects=[patch_Detach1, patch]
  feed_T1: Terminal port=1 Edges=feed.edge(at (-7, 0.1, 2)) TerminalResistance=50ohm
  1: Lumped Port Faces=Rectangle4.face LumpedPortType=Terminal Impedance=50ohm
  reference conductors: feed, patch
setups:
  freq: HfssDriven Frequency=6GHz MaxDeltaS=0.015 MaximumPasses=20 MinimumPasses=1 MinimumConvergedPasses=1 PercentRefinement=30 BasisOrder=1 PortAccuracy=2 DrivenSolverType="Direct Solver" IESolverType=ACA
    sweep Sweep1: 0.5GHz to 8GHz, 5001 points; Type=Interpolating InterpTolerance=0.5 InterpMaxSolns=250 PassivityErrorTolerance=0.0001
source amplitudes:
  1:1: 1V 0deg
optimetrics:
  ParametricSetup1: Parametric
    sweep feedpos: LIN 0.5mm 1.5mm 0.1mm
  ParametricSetup2: Parametric Sim._Setups=[freq]
    sweep muscleR: LIN 20mm 60mm 10mm
output variables:
  eff = RadiatedPower/AcceptedPower
  emis_multiplicator = IncidentPower/AcceptedPower
field plots:
  Average_SAR1, Local_SAR2: SAR Field in Sphere1 on freq : LastAdaptive at Freq=6GHz Phase=0deg
  Local_SAR1: SAR Field over feed.face patch.face(all 3) on freq : LastAdaptive at Freq=6GHz Phase=0deg
reports:
  Terminal S Parameter Plot 1: dB(St(feed_T1,feed_T1)) vs Freq on freq : Sweep1; markers m1 at 4.6684GHz, m2 at 5.9388GHz, m3 at 5.218GHz

design aydnzn_rectangular_slot (HFSS, HFSS Terminal Network, model units mm)
options: Save_Adaptive_support_files
variables:
  subY = 50mm
  patchX = 5.15mm
  subX = 30mm
  patchY = 3.65mm
  subH1 = 2mm
  subH = 1mm
  starter_x_plus = 2.5m
  Gap = 1mm
  feed_width = 1.7mm
  slot_width = 0.5mm
  starter_y_minus = 2.4mm
  feed_off = 3m
  starter = 2.6mm
  starter_y_plus = 2.5mm
  feed_enter = 0.4m
  surface_to_feed_gap = 0.5mm
  width_match = 0.4mm
  oran = (2/3) fraction
  oran_2 = subH*oran bel
  oran_3 = 2/3
  radius_of_sphere = 100mm
  w = patchY+2*slot_width
  lc = 5mm
  tuning_stub = 2mm
geometry:
  implant1 [Rogers RO3210 (tm)] = box(corner=(-subX/2, -subY/2, 0), size=(subX, subY, subH))
  gnd [non-model] = rectangle(corner=(-subX/2, -subY/2, 0), x_size=subX, y_size=subY)
  inner_patch = rectangle(corner=(-patchX/2, -patchY/2, subH), x_size=patchX, y_size=patchY)
  surface = rectangle(corner=(-subX/2, -subY/2, subH), x_size=subX, y_size=subY)
  inner_patch_ext_1 = rectangle(corner=(-patchX/2, -patchY/2, subH), x_size=patchX, y_size=patchY)
  inner_patch_plus_slot_width_extract = rectangle(corner=((-patchX-slot_width)/2, (-patchY-slot_width)/2, subH), x_size=patchX+slot_width, y_size=patchY+slot_width)
  inner_patch_ext1 = rectangle(corner=(-patchX/2, -patchY/2, subH), x_size=patchX, y_size=patchY)
  inner_patch_plus_slot_width_extract.subtract(inner_patch_ext1)
  surface.subtract(inner_patch_ext_1, inner_patch_plus_slot_width_extract)
  feed = rectangle(corner=(patchX/2, -feed_width/2, subH), x_size=subX/2-patchX/2, y_size=feed_width)
  aperture_2_ext = rectangle(corner=(patchX/2, -feed_width/2-surface_to_feed_gap, subH), x_size=subX/2-patchX/2, y_size=feed_width+2*surface_to_feed_gap)
  feed_ext1 = rectangle(corner=(patchX/2, -feed_width/2, subH), x_size=subX/2-patchX/2, y_size=feed_width)
  aperture_2_ext.subtract(feed_ext1)
  feed_ext_2 = rectangle(corner=(patchX/2, -feed_width/2, subH), x_size=subX/2-patchX/2, y_size=feed_width)
  surface.subtract(aperture_2_ext, feed_ext_2)
  inner_patch.unite(feed)
  dummy [non-model] = rectangle(corner=(subX/2, -(feed_width+2*surface_to_feed_gap+2*width_match)/2, 0), y_size=feed_width+2*surface_to_feed_gap+2*width_match, z_size=subH)
  dummy1 = rectangle(corner=(subX/2, -(feed_width+2*surface_to_feed_gap)/2, (1-oran_3)*subH), y_size=feed_width+2*surface_to_feed_gap, z_size=subH*oran_3)
  dummy2 = rectangle(corner=(subX/2, -(feed_width)/2, (1-oran_3)*subH), y_size=feed_width, z_size=subH*oran_3)
  dummy4 = rectangle(corner=(subX/2, -(feed_width+2*surface_to_feed_gap)/2, (1-oran_3)*subH), y_size=feed_width+2*surface_to_feed_gap, z_size=subH*oran_3)
  dummy.subtract(dummy1)
  dummy4.subtract(dummy2)
  inner_patch_plus_slot_width [non-model] = rectangle(corner=((-patchX-slot_width)/2, (-patchY-slot_width)/2, subH), x_size=patchX+slot_width, y_size=patchY+slot_width)
  inner_patch_ext3 = rectangle(corner=(-patchX/2, -patchY/2, subH), x_size=patchX, y_size=patchY)
  inner_patch_plus_slot_width.subtract(inner_patch_ext3)
  aperture_2_ext_2 = rectangle(corner=(patchX/2, -feed_width/2-surface_to_feed_gap, subH), x_size=subX/2-patchX/2, y_size=feed_width+2*surface_to_feed_gap)
  feed_ext4 = rectangle(corner=(patchX/2, -feed_width/2, subH), x_size=subX/2-patchX/2, y_size=feed_width)
  aperture_2_ext_2.subtract(feed_ext4)
  feed_ext_4 = rectangle(corner=(patchX/2, -feed_width/2, subH), x_size=subX/2-patchX/2, y_size=feed_width)
  inner_patch_plus_slot_width.subtract(aperture_2_ext_2, feed_ext_4)
  aperture_3 = rectangle(corner=(patchX/2, -feed_width/2-surface_to_feed_gap, subH), x_size=subX/2-patchX/2, y_size=feed_width+2*surface_to_feed_gap)
  feed_ext3 = rectangle(corner=(patchX/2, -feed_width/2, subH), x_size=subX/2-patchX/2, y_size=feed_width)
  aperture_3.subtract(feed_ext3)
  inner_patch_plus_slot_width.unite(aperture_3)
  inner_patch_plus_slot_width.unite(dummy4)
  Sphere1 [bone_cort_2.4ghz] = sphere(centre=(0mm, 0mm, 0mm), radius=radius_of_sphere)
  implant1_ext = box(corner=(-subX/2, -subY/2, 0), size=(subX, subY, subH))
  Sphere1.subtract(implant1_ext)
  dummy5 = rectangle(corner=(subX/2, -(feed_width+2*surface_to_feed_gap+2*width_match)/2, subH), x_size=subH, y_size=feed_width+2*surface_to_feed_gap+2*width_match)
  dummy6 = rectangle(corner=(subX/2, -(feed_width+2*surface_to_feed_gap)/2, subH), x_size=subH*oran_3, y_size=feed_width+2*surface_to_feed_gap)
  dummy5.subtract(dummy6)
  dummy7 [non-model] = rectangle(corner=(subX/2, -(feed_width)/2, subH), x_size=subH*oran_3, y_size=feed_width)
  dummy8 = rectangle(corner=(subX/2, -(feed_width)/2, subH), x_size=subH*oran_3/2, y_size=feed_width)
  dummy9 = rectangle(corner=(subX/2+subH*oran_3/2, -(feed_width)/2, subH), x_size=subH*oran_3/2, y_size=feed_width)
  dummy8.unite(inner_patch)
  surface.unite(dummy5)
  feed1 = rectangle(corner=(patchX/2, -feed_width/2, subH), x_size=lc+tuning_stub, y_size=feed_width)
boundaries and excitations:
  PerfE1: Perfect E Objects=surface
  PerfE2: Perfect E Objects=dummy8
  dummy8_T1: Terminal port=1 Edges=dummy8.edge(at (15.3333, 0, 1)) TerminalResistance=50ohm
  1: Lumped Port Faces=dummy9.face LumpedPortType=Terminal Impedance=50ohm
  reference conductors: surface
setups:
  Setup1: HfssDriven Frequency=2.4GHz MaxDeltaS=0.015 MaximumPasses=10 MinimumPasses=1 MinimumConvergedPasses=1 PercentRefinement=30 BasisOrder=1 PortAccuracy=2 DrivenSolverType="Direct Solver"
    sweep Sweep: 0.1GHz to 10GHz, 1501 points; Type=Interpolating InterpTolerance=0.5 InterpMaxSolns=250 PassivityErrorTolerance=0.0001
source amplitudes:
  1:1: 1V 0deg
reports:
  Terminal S Parameter Plot 1: dB(St(inner_patch_T1,inner_patch_T1)) vs Freq on Setup1 : Sweep; markers m1 at 2.014GHz, m2 at 1.3936GHz, m3 at 2.8258GHz

design HFSSDesign1 (HFSS, HFSS Terminal Network, model units mm)
options: Save_Adaptive_support_files open_region{BoundaryType=0 OpFreq=4GHz}
variables:
  L = 40mm
  W = 20mm
  H = 1mm
  small_L = 30mm
  small_W = 15mm
  slot_width = 4mm
  feed_width = 4mm
  t = 20mm
  gc = 1mm
  d = 1mm
  radius_of_sphere = 30mm
  feeding_rest = 0.4mm
geometry:
  Box1 [Rogers RO3210 (tm)] = box(corner=(-L/2, -W/2, 0mm), size=(L, W, H))
  groundplane = rectangle(corner=(-L/2, -W/2, H), x_size=L, y_size=W)
  inner_gndplane = rectangle(corner=(-(small_L-2*slot_width)/2, -(small_W-2*slot_width)/2, H), x_size=small_L-2*slot_width, y_size=small_W-2*slot_width)
  inner_feed = rectangle(corner=(L/2-2mm, -(feed_width)/2, H), x_size=-(L/2-(small_L/2)+t)+2mm, y_size=feed_width)
  outer_feed1 = rectangle(corner=(L/2-1mm, -(feed_width+2*gc)/2, H), x_size=-(L/2-(small_L/2)+t+d)+1mm, y_size=feed_width+2*gc)
  inner_gndplane_slots1 = rectangle(corner=(-small_L/2, -small_W/2, H), x_size=small_L, y_size=small_W)
  outer_feed2 = rectangle(corner=(L/2, -(feed_width+2*gc)/2, H), x_size=-(L/2-(small_L/2)+t+d), y_size=feed_width+2*gc)
  inner_gndplane.subtract(outer_feed2)
  Sphere1 [bone_cort_2.4ghz] = sphere(centre=(0mm, 0mm, 0mm), radius=radius_of_sphere)
  Box2 = box(corner=(-L/2, -W/2, 0mm), size=(L, W, H))
  Sphere1.subtract(Box2)
  RadiatingSurface [vacuum] = region(absolute_offset=25mm on all sides)
  inner_feed6 = rectangle(corner=(L/2-1mm, -(feed_width)/2, H), x_size=-1mm, y_size=feed_width)
  groundplane.subtract(inner_gndplane_slots1)
  groundplane.subtract(outer_feed1)
boundaries and excitations:
  PerfE2: Perfect E Objects=inner_gndplane
  PerfE3: Perfect E Objects=inner_feed
  PerfE4: Perfect E Objects=groundplane
  AutoOpen1: Radiation Objects=RadiatingSurface
  inner_feed_T1: Terminal port=1 Edges=inner_feed.edge(at (18, 0, 1)) TerminalResistance=50ohm
  1: Lumped Port Faces=inner_feed6.face LumpedPortType=Terminal Impedance=50ohm
  reference conductors: groundplane, inner_feed
setups:
  Setup1: HfssDriven Frequency=4GHz MaxDeltaS=0.02 MaximumPasses=10 MinimumPasses=1 MinimumConvergedPasses=1 PercentRefinement=30 BasisOrder=-1 PortAccuracy=2 DrivenSolverType="Iterative Solver" IterativeResidual=1e-06 DDMSolverResidual=0.0001
    sweep Sweep: 0.1GHz to 4GHz, 451 points; Type=Interpolating InterpTolerance=0.5 InterpMaxSolns=250 PassivityErrorTolerance=0.0001
    sweep Sweep1: point 1.09GHz; Type=Discrete SaveFields
source amplitudes:
  1:1: 1V 0deg
optimetrics:
  ParametricSetup1: Parametric Sim._Setups=[Setup1]
    sweep slot_width: LIN 0.25mm 1mm 0.25mm
radiation setups:
  3D: Infinite Sphere Theta=0deg..180deg step 2deg Phi=-180deg..180deg step 2deg
  Elevation: Infinite Sphere Theta=-180deg..180deg step 1deg Phi=0deg..90deg step 90deg
  Azimuth: Infinite Sphere Theta=90deg..90deg step 0deg Phi=-180deg..180deg step 1deg
field plots:
  Vector_E1: E Field over groundplane.face(at (0, 0, 1)) inner_feed.face inner_gndplane.face(at (0, 0, 1)) on Setup1 : Sweep1 at Freq=0.2GHz Phase=0deg
reports:
  Terminal S Parameter Plot 4: dB(St(inner_feed6_T1,inner_feed6_T1)) vs Freq on Setup1 : Sweep; markers m1 at 1.7813333GHz, m2 at 2.4226667GHz, m3 at 0.126GHz, m4 at 1.0966667GHz, m5 at 4GHz, m6 at 2.9686667GHz, m7 at 1.5473333GHz
  Antenna Params Plot 1: RadiationEfficiency vs Freq on Setup1 : Sweep1
  Gain Plot 1: dB(GainTotal) vs Phi, Theta on Setup1 : Sweep1, 3D [Freq=1.09GHz]
  Terminal S Parameter Plot 5: dB(St(inner_feed_T1,inner_feed_T1)) vs Freq on Setup1 : Sweep

design transmission (HFSS, HFSS Terminal Network, model units mm)
options: Save_Adaptive_support_files open_region{BoundaryType=0 OpFreq=9GHz}
variables:
  subx = 4cm
  suby = 1cm
  subH = 1mm
  width_TL = 3.75mm
  width_GAP = width_TL/2+0.15mm
geometry:
  Box1 [Duroid (tm)] = box(corner=(-subx/2, -suby/2, 0mm), size=(subx, suby, subH))
  TL = rectangle(corner=(-subx/2+2mm, -width_TL/2, subH), x_size=subx-4mm, y_size=width_TL)
  GAP = rectangle(corner=(-subx/2, -width_GAP, subH), x_size=subx, y_size=2*width_GAP)
  Up_GROUND = rectangle(corner=(-subx/2, -suby/2, subH), x_size=subx, y_size=suby)
  Up_GROUND.subtract(GAP)
  lump_Helper = rectangle(corner=(subx/2, -width_GAP, subH), x_size=-1mm, y_size=2*width_GAP)
  Lumped = rectangle(corner=(subx/2-1mm, -width_TL/2, subH), x_size=-1mm, y_size=width_TL)
  lump_Helper_1 = lump_Helper.duplicate_mirror(point=(0mm, 2mm, 0mm), normal=(1mm, 0mm, 0mm))
  Lumped_1 = Lumped.duplicate_mirror(point=(0mm, 0mm, 1mm), normal=(1mm, 0mm, 0mm))
  RadiatingSurface [vacuum] = region(absolute_offset=11.111111mm on all sides)
  Box2 [Duroid (tm)] = box(corner=(-subx/2, -suby/2+10cm, 0mm), size=(subx, suby, subH))
  TL1 = rectangle(corner=(-subx/2, -width_TL/2+10cm, subH), x_size=subx, y_size=width_TL)
  Up_GROUND1 = rectangle(corner=(-subx/2, -suby/2+10cm, subH), x_size=subx, y_size=suby)
  GAP1 = rectangle(corner=(-subx/2, -width_GAP, subH), x_size=subx, y_size=2*width_GAP)
  Up_GROUND1.subtract(GAP1)
  GAP2 = rectangle(corner=(-subx/2, -width_GAP+10cm, subH), x_size=subx, y_size=2*width_GAP)
  Up_GROUND1.subtract(GAP2)
  Waveport1 [pec] = box(corner=(-subx/2, 10cm-width_GAP*3, subH*-6), size=(-2mm, width_GAP*6, subH*12))
  Waveport1_1 [pec] = Waveport1.duplicate_mirror(point=(0mm, 99mm, 0mm), normal=(-1mm, 0mm, 0mm))
boundaries and excitations:
  Line: Perfect E Objects=TL
  ground: Perfect E Objects=[lump_Helper, lump_Helper_1, Up_GROUND]
  AutoOpen1: Radiation Objects=RadiatingSurface
  line2: Perfect E Objects=TL1
  ground2: Perfect E Objects=Up_GROUND1
  11: Terminal port=1 Edges=TL.edge(at (18, 0, 1)) TerminalResistance=50ohm
  22: Terminal port=2 Edges=TL.edge(at (-18, 0, 1)) TerminalResistance=50ohm
  33: Terminal port=3 Edges=TL1.edge(at (20, 100, 1)) TerminalResistance=50ohm
  44: Terminal port=4 Edges=TL1.edge(at (-20, 100, 1)) TerminalResistance=50ohm
  1: Lumped Port Faces=Lumped.face(at (18.5, 0, 1)) LumpedPortType=Terminal Impedance=50ohm
  2: Lumped Port Faces=Lumped_1.face LumpedPortType=Terminal Impedance=50ohm
  3: Wave Port Faces=Waveport1_1.face(at (20, 100, 0)) WavePortType=Terminal NumModes=1
  4: Wave Port Faces=Waveport1.face(+x) WavePortType=Terminal NumModes=1
  reference conductors: Up_GROUND1, Waveport1
setups:
  Setup1: HfssDriven Frequency=9GHz MaxDeltaS=0.02 MaximumPasses=7 MinimumPasses=1 MinimumConvergedPasses=1 PercentRefinement=30 BasisOrder=1 PortAccuracy=2 DrivenSolverType="Direct Solver"
    sweep Sweep: 1GHz to 9GHz, 1001 points; Type=Interpolating InterpTolerance=0.5 InterpMaxSolns=250 PassivityErrorTolerance=0.0001
source amplitudes:
  1:1: 1V 0deg
  2:1, 3:1, 4:1: 0V 0deg
optimetrics:
  ParametricSetup1: Parametric Sim._Setups=[Setup1]
    sweep width_TL: LIN 0.681555mm 2.044665mm 0.2mm
radiation setups:
  3D: Infinite Sphere Theta=0deg..180deg step 2deg Phi=-180deg..180deg step 2deg
  Elevation: Infinite Sphere Theta=-180deg..180deg step 1deg Phi=0deg..90deg step 90deg
  Azimuth: Infinite Sphere Theta=90deg..90deg step 0deg Phi=-180deg..180deg step 1deg
reports:
  S31: dB(St(33,33)), dB(St(44,33)), dB(St(33,44)) vs Freq on Setup1 : Sweep
  s11: dB(St(11,11)), dB(St(22,11)) vs Freq on Setup1 : Sweep
  Terminal S Parameter Plot 1: dB(St(22,11)), dB(St(44,33)) vs Freq on Setup1 : Sweep
